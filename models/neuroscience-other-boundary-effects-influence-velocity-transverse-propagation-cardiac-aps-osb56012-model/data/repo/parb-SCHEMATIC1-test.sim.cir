** Profile: "SCHEMATIC1-test"  [ E:\kp\cardiac_parallel\parb-schematic1-test.sim ]

** Creating circuit file "parb-schematic1-test.sim.cir"
** WARNING: THIS AUTOMATICALLY GENERATED FILE MAY BE OVERWRITTEN BY SUBSEQUENT SIMULATIONS

*Libraries:
* Local Libraries :
.STMLIB ".\PARB.stl"
* From [PSPICE NETLIST] section of C:\Program Files\Orcad\PSpice\PSpice.ini file:
.lib "nom.lib"

*Analysis directives:
.TRAN  0 5ms 0
.PROBE V(*) I(*) W(*) D(*) NOISE(*)
.INC ".\parb-SCHEMATIC1.net"

.END
